*** SPICE deck for cell adderTestingSized{sch} from library ese370
*** Created on Wed Mar 25, 2026 21:55:32
*** Last revised on Fri Mar 27, 2026 02:16:19
*** Written on Fri Mar 27, 2026 02:55:27 by Electric VLSI Design System, version 9.08
*** Layout tech: mocmos, foundry MOSIS
*** UC SPICE *** , MIN_RESIST 4.0, MIN_CAPAC 0.1FF
* Model cards described in this file:
.include C:\Users\keole\Documents\22nm_HP.pm

*** SUBCIRCUIT ese370__cMOSNegatedSized FROM CELL cMOSNegatedSized{sch}
.SUBCKT ese370__cMOSNegatedSized !cin cnext x y z
** GLOBAL gnd
** GLOBAL vdd

.param w4 = {4 * 0.022u}
.param w16 = {4 * 0.022u}
.param w8 = {1 / (1/w4 + 1/w16)}

Mnmos@42 cnext net@491 net@604 gnd N L=0.022U W=w8
Mnmos@43 net@489 x gnd gnd N L=0.022U W=0.022U
Mnmos@44 net@491 y gnd gnd N L=0.022U W=0.022U
Mnmos@45 net@595 net@561 gnd gnd N L=0.022U W=0.022U
Mnmos@48 net@604 net@489 gnd gnd N L=0.022U W=w8
Mnmos@49 cnext net@491 net@608 gnd N L=0.022U W=w16
Mnmos@50 net@608 !cin gnd gnd N L=0.022U W=w4
Mnmos@51 cnext net@489 net@608 gnd N L=0.022U W=w16
Mnmos@52 net@531 net@491 gnd gnd N L=0.022U W=0.022U
Mnmos@55 net@527 y gnd gnd N L=0.022U W=0.022U
Mnmos@56 net@542 net@489 net@531 gnd N L=0.022U W=0.022U
Mnmos@59 net@542 x net@527 gnd N L=0.022U W=0.022U
Mnmos@60 net@561 !cin gnd gnd N L=0.022U W=0.022U
Mnmos@61 net@830 net@824 net@595 gnd N L=0.022U W=0.176U
Mnmos@62 net@830 net@542 net@561 gnd N L=0.022U W=0.176U
Mnmos@63 net@824 net@542 gnd gnd N L=0.022U W=0.022U
Mnmos@64 z net@830 gnd gnd N L=0.022U W=0.022U
Mpmos@42 vdd !cin net@616 vdd P L=0.022U W=w4
Mpmos@43 net@616 net@489 cnext vdd P L=0.022U W=w16
Mpmos@44 net@616 net@491 cnext vdd P L=0.022U W=w16
Mpmos@45 net@571 net@491 cnext vdd P L=0.022U W=w8
Mpmos@46 vdd net@489 net@571 vdd P L=0.022U W=w8
Mpmos@47 vdd x net@489 vdd P L=0.022U W=0.022U
Mpmos@48 vdd y net@491 vdd P L=0.022U W=0.022U
Mpmos@49 vdd net@561 net@595 vdd P L=0.022U W=0.022U
Mpmos@50 net@528 x net@542 vdd P L=0.022U W=0.022U
Mpmos@51 net@530 net@489 net@542 vdd P L=0.022U W=0.022U
Mpmos@54 vdd net@491 net@528 vdd P L=0.022U W=0.022U
Mpmos@55 vdd y net@530 vdd P L=0.022U W=0.022U
Mpmos@60 vdd !cin net@561 vdd P L=0.022U W=0.022U
Mpmos@61 vdd net@542 net@824 vdd P L=0.022U W=0.022U
Mpmos@62 vdd net@830 z vdd P L=0.022U W=0.022U
.ENDS ese370__cMOSNegatedSized

*** SUBCIRCUIT ese370__cMOSNormalSized FROM CELL cMOSNormalSized{sch}
.SUBCKT ese370__cMOSNormalSized !cnext cin x y z
** GLOBAL gnd
** GLOBAL vdd

.param w4 = {4 * 0.022u}
.param w16 = {4 * 0.022u}
.param w8 = {1 / (1/w4 + 1/w16)}

Mnmos@28 !cnext y net@479 gnd N L=0.022U W=w8
Mnmos@29 net@356 x gnd gnd N L=0.022U W=0.022U
Mnmos@30 net@391 y gnd gnd N L=0.022U W=0.022U
Mnmos@31 net@460 net@247 gnd gnd N L=0.022U W=0.022U
Mnmos@36 net@479 x gnd gnd N L=0.022U W=w8
Mnmos@37 !cnext y net@484 gnd N L=0.022U W=w16
Mnmos@39 net@484 cin gnd gnd N L=0.022U W=w4
Mnmos@40 !cnext x net@484 gnd N L=0.022U W=w16
Mnmos@49 net@247 cin gnd gnd N L=0.022U W=0.022U
Mnmos@50 net@671 net@391 gnd gnd N L=0.022U W=0.022U
Mnmos@51 net@668 y gnd gnd N L=0.022U W=0.022U
Mnmos@52 net@672 net@356 net@671 gnd N L=0.022U W=0.022U
Mnmos@53 net@672 x net@668 gnd N L=0.022U W=0.022U
Mnmos@54 net@693 net@691 net@247 gnd N L=0.022U W=0.176U
Mnmos@55 net@693 net@672 net@460 gnd N L=0.022U W=0.176U
Mnmos@56 net@691 net@672 gnd gnd N L=0.022U W=0.022U
Mnmos@57 z net@693 gnd gnd N L=0.022U W=0.022U
Mpmos@28 vdd cin net@494 vdd P L=0.022U W=w4
Mpmos@29 net@494 x !cnext vdd P L=0.022U W=w16
Mpmos@30 net@494 y !cnext vdd P L=0.022U W=w16
Mpmos@31 net@419 y !cnext vdd P L=0.022U W=w8
Mpmos@32 vdd x net@419 vdd P L=0.022U W=w8
Mpmos@33 vdd x net@356 vdd P L=0.022U W=0.022U
Mpmos@34 vdd y net@391 vdd P L=0.022U W=0.022U
Mpmos@36 vdd net@247 net@460 vdd P L=0.022U W=0.022U
Mpmos@49 vdd cin net@247 vdd P L=0.022U W=0.022U
Mpmos@50 net@669 x net@672 vdd P L=0.022U W=0.022U
Mpmos@51 net@670 net@356 net@672 vdd P L=0.022U W=0.022U
Mpmos@52 vdd net@391 net@669 vdd P L=0.022U W=0.022U
Mpmos@53 vdd y net@670 vdd P L=0.022U W=0.022U
Mpmos@54 vdd net@672 net@691 vdd P L=0.022U W=0.022U
Mpmos@55 vdd net@693 z vdd P L=0.022U W=0.022U
.ENDS ese370__cMOSNormalSized

.global gnd vdd

*** TOP LEVEL CELL: adderTestingSized{sch}

*** delay
*** VVPulse@2 x0 gnd pulse (0 0.0V 0ns 0ps 0ps 4ns 4ns) DC 0V AC 0V 0
*** VVPulse@3 y1 gnd pulse (0 1.0V 0ns 0ps 0ps 4ns 4ns) DC 0V AC 0V 0
*** VVPulse@4 xin gnd pulse (0 1.0V 0ns 5ps 5ps 500ps 1ns) DC 0V AC 0V 0

*** switching energy - full
*** VVPulse@2 x0 gnd pulse (0 1.0V 0ns 5ps 5ps 500ps 1ns) DC 0V AC 0V 0
*** VVPulse@3 y1 gnd pulse (0 1.0V 0ns 5ps 5ps 500ps 1ns) DC 0V AC 0V 0
*** VVPulse@4 xin gnd pulse (0 1.0V 0ns 5ps 5ps 500ps 1ns) DC 0V AC 0V 0

*** switching energy - half
*** VVPulse@2 x0 gnd pulse (0 1.0V 0ns 5ps 5ps 500ps 1ns) DC 0V AC 0V 0
*** VVPulse@3 y1 gnd pulse (0 0.0V 0ns 5ps 5ps 500ps 1ns) DC 0V AC 0V 0
*** VVPulse@4 xin gnd pulse (0 1.0V 0ns 5ps 5ps 500ps 1ns) DC 0V AC 0V 0

*** leakage - worst
*** VVPulse@2 x0 gnd pulse (0 0.0V 0ns 0ps 0ps 4ns 4ns) DC 0V AC 0V 0
*** VVPulse@3 y1 gnd pulse (0 1.0V 0ns 0ps 0ps 4ns 4ns) DC 0V AC 0V 0
*** VVPulse@4 xin gnd pulse (0 0.0V 0ns 0ps 0ps 4ns 4ns) DC 0V AC 0V 0

*** leakage - best
VVPulse@2 evens gnd pulse (0 0.0V 0ns 0ps 0ps 4ns 4ns) DC 0V AC 0V 0
VVPulse@3 odds gnd pulse (0 1.0V 0ns 0ps 0ps 4ns 4ns) DC 0V AC 0V 0

VV_Generi@1 vdd gnd DC 1.0 AC 0

*** everything besides best-case leakage
*** XcMOSNega@2 c1 c2 x0 y1 cMOSNega@2_z ese370__cMOSNegatedSized
*** XcMOSNega@3 c3 c4 x0 y1 cMOSNega@3_z ese370__cMOSNegatedSized
*** XcMOSNega@4 c5 c6 x0 y1 cMOSNega@4_z ese370__cMOSNegatedSized
*** XcMOSNega@5 c7 clast x0 y1 zlast ese370__cMOSNegatedSized
*** XcMOSNega@6 net@215 net@216 gnd gnd cMOSNega@6_z ese370__cMOSNegatedSized
*** XcMOSNorm@1 c1 net@216 xin y1 cMOSNorm@1_z ese370__cMOSNormalSized
*** XcMOSNorm@2 c3 c2 x0 y1 cMOSNorm@2_z ese370__cMOSNormalSized
*** XcMOSNorm@3 c5 c4 x0 y1 cMOSNorm@3_z ese370__cMOSNormalSized
*** XcMOSNorm@4 c7 c6 x0 y1 cMOSNorm@4_z ese370__cMOSNormalSized
*** XcMOSNorm@5 cMOSNorm@5_!cnext clast gnd gnd cMOSNorm@5_z ese370__cMOSNormalSized
*** XcMOSNorm@6 net@215 gnd gnd gnd cMOSNorm@6_z ese370__cMOSNormalSized

*** best-case leakage
XcMOSNega@2 c1 c2 evens evens cMOSNega@2_z ese370__cMOSNegatedSized
XcMOSNega@3 c3 c4 evens evens cMOSNega@3_z ese370__cMOSNegatedSized
XcMOSNega@4 c5 c6 evens evens cMOSNega@4_z ese370__cMOSNegatedSized
XcMOSNega@5 c7 clast evens evens zlast ese370__cMOSNegatedSized
XcMOSNega@6 net@215 net@216 gnd gnd cMOSNega@6_z ese370__cMOSNegatedSized
XcMOSNorm@1 c1 net@216 odds odds cMOSNorm@1_z ese370__cMOSNormalSized
XcMOSNorm@2 c3 c2 odds odds cMOSNorm@2_z ese370__cMOSNormalSized
XcMOSNorm@3 c5 c4 odds odds cMOSNorm@3_z ese370__cMOSNormalSized
XcMOSNorm@4 c7 c6 odds odds cMOSNorm@4_z ese370__cMOSNormalSized
XcMOSNorm@5 cMOSNorm@5_!cnext clast gnd gnd cMOSNorm@5_z ese370__cMOSNormalSized
XcMOSNorm@6 net@215 gnd gnd gnd cMOSNorm@6_z ese370__cMOSNormalSized
.END

*** make the graph prettier
*** set color0 = white color1 = black color2 = red color3 = blue

*** delay cascade
*** source adderTestingSized.spi ; tran 1ps 2ns ; plot xin c1 c2 c3 c4 c5 c6 c7 clast
*** z cascade
*** source adderTestingSized.spi ; tran 1ps 2ns ; plot xin zlast

*** switching energy
*** source adderTestingSized.spi ; tran 1ps 2ns; meas tran energy INTEG i(vv_generi@1) FROM=500p TO=1000p ; meas tran energy INTEG i(vv_generi@1) FROM=1000p TO=1500p

*** static energy
*** source adderTestingSized.spi ; tran 1ps 2ns; meas tran energy INTEG i(vv_generi@1) FROM=500p TO=652.112p
