*** SPICE deck for cell HW3_Q6{sch} from library ese370
*** Created on Thu Feb 12, 2026 14:35:20
*** Last revised on Fri Feb 13, 2026 01:17:35
*** Written on Fri Feb 13, 2026 01:18:38 by Electric VLSI Design System, version 9.08
*** Layout tech: mocmos, foundry MOSIS
*** UC SPICE *** , MIN_RESIST 4.0, MIN_CAPAC 0.1FF
* Model cards described in this file:
.include C:\Users\keole\Documents\22nm_HP.pm

.global gnd vdd

*** TOP LEVEL CELL: HW3_Q6{sch}
Mnmos@0 vdd input output gnd N L=0.022U W=0.022U
Mpmos@0 output input gnd vdd P L=0.022U W=0.022U
VV_Generi@1 input gnd DC 0.8 AC 0
VV_Generi@2 vdd gnd DC 0.8 AC 0
.END

*** source HW3_Q6.spi <-- open circuit in ngspice
*** dc vv_generi@1 0 0.8 0.01 <-- simulate DC analysis on generic source 1
*** set color0 = white color1 = black color2 = red color3 = blue <-- make the graph prettier
*** plot input output <-- input and output
